* Test coupling
Vin in 0 10
R1 in 1 1
L1 1 0 1m
L2 2 0 1m
K1 L1 L2 0.9
R2 2 0 10
.tran 1u 10u
.end
